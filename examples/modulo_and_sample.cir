Modulo integrator and sampler example

.control
pre_codemodel build/ngfuncs.cm
.endc

.include lib/ngfuncs.lib

Vin in 0 dc 1
Vsig sig 0 sin(0 1 5)
Vclk clk 0 pulse(0 1 0.05 1n 1n 0.05 0.2)

Xphase in phase NG_INT_MOD params: ic=0 gain=1 modulus=1
Xsamp sig clk held NG_SAMPLE_RISE params: ic=0 vth=0.5
Xslope sig slope NG_DDT params: gain=1

Rin in 0 1G
Rs sig 0 1G
Rc clk 0 1G
Rp phase 0 1G
Rh held 0 1G
Rd slope 0 1G

.tran 1m 1.2

.control
run
plot v(phase) v(clk) v(held)
plot v(sig) v(slope)
.endc

.end
