Resettable integrator regression

.control
pre_codemodel build/ngfuncs.cm
.endc

.include lib/ngfuncs.lib

Vin in 0 dc 1
Vrst rst 0 pwl(0 0 0.5 0 0.500001 1 0.51 1 0.510001 0 1 0)

Xint in rst out NG_INT_RISE params: ic=0.25 gain=1 vth=0.5

Rin in 0 1G
Rrst rst 0 1G
Rout out 0 1G

.tran 0.5m 0.9

.control
run
meas tran before FIND v(out) at=0.49
meas tran after FIND v(out) at=0.505
meas tran later FIND v(out) at=0.705
if (abs(before - 0.74) < 0.02) & (abs(after - 0.255) < 0.02) & (abs(later - 0.455) < 0.03)
  echo TEST PASS integrator_reset
  quit 0
else
  echo TEST FAIL integrator_reset
  print before after later
  quit 1
end
.endc

.end
