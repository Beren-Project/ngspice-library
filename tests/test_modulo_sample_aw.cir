Modulo, sample, and anti-windup regression

.control
pre_codemodel build/ngfuncs.cm
.endc

.include lib/ngfuncs.lib

Vin in 0 dc 1
Vsig sig 0 pwl(0 0 0.2 2 0.4 4 0.6 6)
Vclk clk 0 pwl(0 0 0.24 0 0.240001 1 0.28 1 0.280001 0 0.6 0)
Vrst rst 0 dc 0

Xmod in phase NG_INT_MOD params: ic=0 gain=1 modulus=0.25
Xsamp sig clk held NG_SAMPLE_RISE params: ic=-1 vth=0.5
Xaw in rst awout NG_INT_AW_PULSE params: ic=0 gain=1 lo=-1 hi=0.1 vth=0.5

Rin in 0 1G
Rs sig 0 1G
Rc clk 0 1G
Rr rst 0 1G
Rp phase 0 1G
Rh held 0 1G
Ra awout 0 1G

.tran 0.25m 0.55

.control
run
meas tran phase_after_wrap FIND v(phase) at=0.255
meas tran held_after_sample FIND v(held) at=0.35
meas tran aw_clamped MAX v(awout) from=0.2 to=0.5
if (phase_after_wrap < 0.03) & (abs(held_after_sample - 2.4) < 0.08) & (abs(aw_clamped - 0.1) < 0.02)
  echo TEST PASS modulo_sample_aw
  quit 0
else
  echo TEST FAIL modulo_sample_aw
  print phase_after_wrap held_after_sample aw_clamped
  quit 1
end
.endc

.end
