Smooth comparator asymmetric slew regression

.include lib/ngfuncs.lib

Vin in 0 pwl(0 -20m 0.2m -20m 0.200001m 20m 0.6m 20m 0.600001m -20m 1m -20m)
Vref ref 0 dc 0

Xcomp in ref out NG_COMP_SMOOTH_DIFF params: vlow=0 vhigh=1 vsmooth=1m trise=80u tfall=200u

Rin in 0 1G
Rref ref 0 1G
Rout out 0 1G

.tran 0.5u 1m

.control
run
meas tran rise_time TRIG v(out) val=0.1 rise=1 TARG v(out) val=0.9 rise=1
meas tran fall_time TRIG v(out) val=0.9 fall=1 TARG v(out) val=0.1 fall=1
meas tran rise_q1 FIND v(out) at=0.22m
meas tran rise_q2 FIND v(out) at=0.24m
meas tran rise_q3 FIND v(out) at=0.26m
meas tran fall_q1 FIND v(out) at=0.65m
meas tran fall_q2 FIND v(out) at=0.70m
meas tran fall_q3 FIND v(out) at=0.75m
meas tran out_min MIN v(out)
meas tran out_max MAX v(out)
if (abs(rise_time - 80u) < 2u) & (abs(fall_time - 200u) < 3u) & (rise_q1 < rise_q2) & (rise_q2 < rise_q3) & (fall_q1 > fall_q2) & (fall_q2 > fall_q3) & (out_min > -1m) & (out_max < 1.001)
  echo TEST PASS comparator_dynamic
  quit 0
else
  echo TEST FAIL comparator_dynamic
  print rise_time fall_time rise_q1 rise_q2 rise_q3 fall_q1 fall_q2 fall_q3 out_min out_max
  quit 1
end
.endc

.end
