Anti-windup rising-edge reset integrator regression

.control
pre_codemodel build/ngfuncs.cm
.endc

.include lib/ngfuncs.lib

Vin in 0 pwl(0 1 0.30 1 0.300001 -1 1.75 -1 1.750001 1 2.10 1)
Vrst rst 0 pwl(0 0 0.45 0 0.450001 1 0.47 1 0.470001 0 2.10 0)

Xaw in rst awout NG_INT_AW_RISE params: ic=0 gain=1 lo=-1 hi=0.1 vth=0.5

Rin in 0 1G
Rrst rst 0 1G
Ra awout 0 1G

.tran 0.5m 2.1

.control
run
meas tran pos_clamp MAX v(awout) from=0.12 to=0.28
meas tran after_reverse FIND v(awout) at=0.36
meas tran after_rise_reset FIND v(awout) at=0.46
meas tran after_fall_no_reset FIND v(awout) at=0.475
meas tran after_reset_down FIND v(awout) at=0.70
meas tran neg_clamp MIN v(awout) from=1.55 to=1.74
meas tran after_positive_resume FIND v(awout) at=1.90
if (abs(pos_clamp - 0.1) < 0.02) & (abs(after_reverse - 0.04) < 0.04) & (abs(after_rise_reset + 0.01) < 0.025) & (abs(after_fall_no_reset + 0.025) < 0.025) & (abs(after_reset_down + 0.25) < 0.04) & (abs(neg_clamp + 1) < 0.03) & (abs(after_positive_resume + 0.85) < 0.06)
  echo TEST PASS integrator_antiwindup_rise
  quit 0
else
  echo TEST FAIL integrator_antiwindup_rise
  print pos_clamp after_reverse after_rise_reset after_fall_no_reset after_reset_down neg_clamp after_positive_resume
  quit 1
end
.endc

.end
