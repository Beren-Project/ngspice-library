Derivative wrapper regression

.control
pre_codemodel build/ngfuncs.cm
.endc

.include lib/ngfuncs.lib

Vin in 0 pwl(0 0 0.6 1.2)

Xddt in slope NG_DDT params: gain=1

Rin in 0 1G
Rslope slope 0 1G

.tran 0.25m 0.6

.control
run
meas tran slope_avg AVG v(slope) from=0.20 to=0.50
meas tran slope_mid FIND v(slope) at=0.30
if (abs(slope_avg - 2.0) < 0.05) & (abs(slope_mid - 2.0) < 0.05)
  echo TEST PASS derivative
  quit 0
else
  echo TEST FAIL derivative
  print slope_avg slope_mid
  quit 1
end
.endc

.end
