Derivative wrapper ramp and pulse input regression

.control
pre_codemodel build/ngfuncs.cm
.endc

.include lib/ngfuncs.lib

Vramp ramp_in 0 pwl(0 0 0.55 1.1)
Xddt1 ramp_in ramp_ddt NG_DDT params: gain=1

Vpulse pulse_in 0 pwl(0 0 0.10 0 0.101 1 0.20 1 0.201 0 0.32 0 0.321 1 0.43 1 0.431 0 0.55 0)
Xddt2 pulse_in pulse_ddt NG_DDT params: gain=1

Rramp ramp_in 0 1G
Rrampddt ramp_ddt 0 1G
Rpulse pulse_in 0 1G
Rpulseddt pulse_ddt 0 1G

.tran 0.05m 0.55

.control
run
meas tran ramp_slope_avg AVG v(ramp_ddt) from=0.05 to=0.50
meas tran ramp_slope_mid FIND v(ramp_ddt) at=0.30
meas tran first_rise AVG v(pulse_ddt) from=0.1002 to=0.1008
meas tran first_high_flat AVG v(pulse_ddt) from=0.13 to=0.18
meas tran first_fall AVG v(pulse_ddt) from=0.2002 to=0.2008
meas tran low_flat AVG v(pulse_ddt) from=0.24 to=0.30
meas tran second_rise AVG v(pulse_ddt) from=0.3202 to=0.3208
meas tran second_fall AVG v(pulse_ddt) from=0.4302 to=0.4308
if (abs(ramp_slope_avg - 2.0) < 0.05) & (abs(ramp_slope_mid - 2.0) < 0.05) & (abs(first_rise - 1000) < 80) & (abs(first_high_flat) < 0.05) & (abs(first_fall + 1000) < 80) & (abs(low_flat) < 0.05) & (abs(second_rise - 1000) < 80) & (abs(second_fall + 1000) < 80)
  echo TEST PASS derivative
  quit 0
else
  echo TEST FAIL derivative
  print ramp_slope_avg ramp_slope_mid first_rise first_high_flat first_fall low_flat second_rise second_fall
  quit 1
end
.endc

.end
