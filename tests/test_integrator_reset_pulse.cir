Resettable integrator pulse reset regression

.control
pre_codemodel build/ngfuncs.cm
.endc

.include lib/ngfuncs.lib

Vin in 0 dc 1
Vrst rst 0 pwl(0 0 0.2 0 0.200001 1 0.22 1 0.220001 0 0.5 0 0.500001 1 0.52 1 0.520001 0 0.75 0 0.750001 1 0.77 1 0.770001 0 0.9 0)

Xint in rst out NG_INT_PULSE params: ic=0.25 gain=1 vth=0.5

Rin in 0 1G
Rrst rst 0 1G
Rout out 0 1G

.tran 0.5m 0.9

.control
run
meas tran before_first FIND v(out) at=0.19
meas tran during_first FIND v(out) at=0.21
meas tran after_first FIND v(out) at=0.30
meas tran during_second FIND v(out) at=0.51
meas tran after_second FIND v(out) at=0.60
meas tran during_third FIND v(out) at=0.76
meas tran after_third FIND v(out) at=0.85
if (abs(before_first - 0.44) < 0.02) & (abs(during_first - 0.25) < 0.02) & (abs(after_first - 0.33) < 0.03) & (abs(during_second - 0.25) < 0.02) & (abs(after_second - 0.33) < 0.03) & (abs(during_third - 0.25) < 0.02) & (abs(after_third - 0.33) < 0.03)
  echo TEST PASS integrator_reset_pulse
  quit 0
else
  echo TEST FAIL integrator_reset_pulse
  print before_first during_first after_first during_second after_second during_third after_third
  quit 1
end
.endc

.end
